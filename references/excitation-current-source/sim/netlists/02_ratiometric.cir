* 02_ratiometric.cir -- ratiometric correctness / sanity (TESTING_PLAN Part 1, test 2)
*
* Sweep the RTD; compute R_calc = R_ref * V_RTD / V_ref from the SOLVED node voltages.
* PASS: R_calc == swept RTD value to within numerical error -- proves the topology and
* that the result is independent of the source current AND of finite source Rout (the
* same series current flows through R_ref and the RTD, so the ratio is exact).
* Tight tolerances so the residual is pure solver noise, not model error.

.include netlists/_generated_params.inc
.include models/ref200.lib

Vrail rail 0 dc {v_rail}
Xsrc  rail topref ref200_src iset={i_exc} rout={rout_src}
Rref  topref rtd_hi {r_ref}
Vsw   sweep 0 dc 0
Rrtd  rtd_hi 0 R = '{r_rtd_min} + ({r_rtd_max}-{r_rtd_min})/100 * v(sweep)'

.options reltol=1e-12 abstol=1e-18 vntol=1e-15 gmin=1e-15

.control
set wr_singlescale
set wr_vecnames
dc Vsw 0 100 1
let r_rtd  = {r_rtd_min} + ({r_rtd_max}-{r_rtd_min})/100 * v(sweep)
let v_rtd  = v(rtd_hi)
let v_ref  = v(topref) - v(rtd_hi)
let r_calc = r_ref * v_rtd / v_ref
let err_abs = r_calc - r_rtd
let err_ppm = 1e6 * (r_calc - r_rtd) / r_rtd
wrdata scratch/02_ratiometric.data r_rtd v_rtd v_ref r_calc err_abs err_ppm
.endc
.end
