* 01_dc_op.cir -- DC operating point & compliance margin (TESTING_PLAN Part 1, test 1)
*
* Sweep the RTD across its full operating band at nominal and worst-case-low supply.
* Records the voltage ACROSS the REF200 source (rail - top node) = its compliance
* headroom. PASS: headroom >= 2.5 V (target >= 3 V) at the highest RTD R and lowest
* supply. Run from cwd = sim/ (see sim/scripts/run_all.py).
*
* Topology (one unit cell, board_spec section 1):
*   rail --[REF200 src: Iexc || Rout]--> topref --[R_ref]--> rtd_hi --[R_rtd]--> 0
*   V_ref  = v(topref) - v(rtd_hi)   ;  V_RTD = v(rtd_hi) - 0
*   headroom across source = v(rail) - v(topref)

.include netlists/_generated_params.inc
.include models/ref200.lib

* --- nominal-supply unit cell ---
Vrail   rail 0 dc {v_rail}
Xsrc    rail topref ref200_src iset={i_exc} rout={rout_src}
Rref    topref rtd_hi {r_ref}
Vsw     sweep 0 dc 0
Rrtd    rtd_hi 0 R = '{r_rtd_min} + ({r_rtd_max}-{r_rtd_min})/100 * v(sweep)'

* --- worst-case-low-supply copy of the same cell (independent net suffix _lo) ---
Vrail2  rail_lo 0 dc {v_rail_min}
Xsrc2   rail_lo topref_lo ref200_src iset={i_exc} rout={rout_src}
Rref2   topref_lo rtd_hi_lo {r_ref}
Rrtd2   rtd_hi_lo 0 R = '{r_rtd_min} + ({r_rtd_max}-{r_rtd_min})/100 * v(sweep)'

.options reltol=1e-9 abstol=1e-15 vntol=1e-12

.control
set wr_singlescale
set wr_vecnames
dc Vsw 0 100 1
let r_rtd     = {r_rtd_min} + ({r_rtd_max}-{r_rtd_min})/100 * v(sweep)
let v_rtd_nom = v(rtd_hi)
let v_ref_nom = v(topref) - v(rtd_hi)
let head_nom  = v(rail) - v(topref)
let head_lo   = v(rail_lo) - v(topref_lo)
wrdata scratch/01_dc_op.data r_rtd v_rtd_nom v_ref_nom head_nom head_lo
.endc
.end
